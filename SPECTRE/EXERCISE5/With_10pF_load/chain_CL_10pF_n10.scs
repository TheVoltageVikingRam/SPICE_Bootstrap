simulator lang=spectre

global 0 vdd vss
include "./22nm_HP.pm"

vdd_I1 ( vdd 0 ) vsource dc=0.8
vss_I1 ( vss 0 ) vsource dc=0
vin ( in0 0 ) vsource type=pulse val0=0 val1=0.8 delay=0 rise=1.0p fall=1.0p width=6n period=12n

*************INVERTER************
subckt inv ( in out vdd vss )
parameters L=22n Ln=L Wn=2*Ln k=1.3 mult=1 wf=220n

parameters Wtot_n=Wn*mult
parameters Wtot_p=k*Wn*mult

parameters nf_n=max(1,ceil(Wtot_n/wf))
parameters nf_p=max(1,ceil(Wtot_p/wf))

// parameters Wf_n=Wtot_n/nf_n
// parameters Wf_p=Wtot_p/nf_p

m1 ( out in vdd vdd ) pmos l=L w=Wtot_p nf=nf_p
m2 ( out in vss vss ) nmos l=L w=Wtot_n nf=nf_n

ends inv

parameters alpha=2.929966326

X0 ( in0 nd0 vdd vss ) inv mult=alpha**0
X1 ( nd0 nd1 vdd vss ) inv mult=alpha**1
X2 ( nd1 nd2 vdd vss ) inv mult=alpha**2
X3 ( nd2 nd3 vdd vss ) inv mult=alpha**3
X4 ( nd3 nd4 vdd vss ) inv mult=alpha**4
x5 ( nd4 nd5 vdd vss ) inv mult=alpha**5
X6 ( nd5 nd6 vdd vss ) inv mult=alpha**6
X7 ( nd6 nd7 vdd vss ) inv mult=alpha**7
X8 ( nd7 nd8 vdd vss ) inv mult=alpha**8
X9 ( nd8 nd9 vdd vss ) inv mult=alpha**9
X10 ( nd9 out vdd vss ) inv mult=alpha**10

CL (out 0) capacitor c=10p

tran_run1 tran stop=11n step=1p

simulator lang=spice

.MEASURE TRAN tPHL
+ TRIG V(in0) VAL=0.4 FALL=1
+ TARG V(out) VAL=0.4 RISE=1

.MEASURE TRAN tPLH
+ TRIG V(in0) VAL=0.4 RISE=1
+ TARG V(out) VAL=0.4 FALL=1

.MEASURE TRAN tpd param='(tPLH+tPHL)/2'
