simulator lang=spectre

global 0

parameters Wn=44n Ln=22n k=1.3 Lp=22n  Wp=k*Wn  VDD=0.8

include "./22nm_HP.pm"
include "./hi_vt_22nm_HP.pm"

VDD_SRC ( vdd 0 ) vsource dc=VDD
VSS_SRC ( vss 0 ) vsource dc=0

parameters S=0.8
VSLEEP ( s 0 ) vsource dc=S

MHEAD ( vdd_int s vdd vdd ) pmos_hvt w=Wp l=Lp

parameters Sbar=0
VSLEEP_N ( sf 0 ) vsource dc=Sbar

MFOOT ( vss_int sf vss vss ) nmos_hvt w=Wn l=Ln

M1 ( out a vdd_int vdd ) pmos w=Wp l=Lp
M2 ( out b vdd_int vdd ) pmos w=Wp l=Lp

M3 ( mid a vss_int vss ) nmos w=Wn l=Ln

M4 ( out b mid vss ) nmos w=Wn l=Ln

parameters VAIN=0 VBIN=0

VINA ( a 0 ) vsource dc=VAIN
VINB ( b 0 ) vsource dc=VBIN

sweepA sweep param=VAIN values=[0 0.8]{

sweepB sweep param=VBIN values=[0 0.8]

{
dcOp dc
}

}

save out
save mid
save vdd_int
save vss_int
save VDD_SRC:p

simulator lang=spice

.options gmindc=1e-15 iabstol=1e-15 reltol=1e-4
