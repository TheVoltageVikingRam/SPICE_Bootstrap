simulator lang=spectre

global 0

parameters VDD=0.8
parameters Rtot=100
parameters Ctot=1p
parameters N=1
parameters TRP=0.632
parameters VTH=TRP*VDD

// Input

Vin ( in 0 ) vsource type=pulse val0=0 val1=VDD delay=0 rise=5.65p fall=5.65p width=500p period=1n

if (N==1) {

	R1 ( in out ) resistor r=Rtot
	C1 ( in 0 ) capacitor c=Ctot/2
	C2 ( out 0 ) capacitor c=Ctot/2

}

if (N==2) {
	parameters Rs=Rtot/2
	parameters Ce=Ctot/4
	parameters Ci=Ctot/2

	R1 ( in n1 ) resistor r=Rs
	C1 ( in 0 ) capacitor c=Ce
	C2 ( n1 0 ) capacitor c=Ci

	R2 ( n1 out ) resistor r=Rs
	C3 ( out 0 ) capacitor c=Ce

}

if (N==3) {
	parameters Rs=Rtot/3
	parameters Ce=Ctot/6
	parameters Ci=Ctot/3

	R1 ( in n1 ) resistor r=Rs
	C1 ( in 0 ) capacitor c=Ce
	C2 ( n1 0 ) capacitor c=Ci

	R2 ( n1 n2 ) resistor r=Rs
	C3 ( n2 0 ) capacitor c=Ci

	R3 ( n2 out ) resistor r=Rs
	C4 ( out 0 ) capacitor c=Ce
}

if (N==4) {
	parameters Rs=Rtot/4
	parameters Ce=Ctot/8
	parameters Ci=Ctot/4

	R1 ( in n1 ) resistor r=Rs
	C1 ( in 0 ) capacitor c=Ce
	C2 ( n1 0 ) capacitor c=Ci

	R2 ( n1 n2 ) resistor r=Rs
	C3 ( n2 0 ) capacitor c=Ci

	R3 ( n2 n3 ) resistor r=Rs
	C4 ( n3 0 ) capacitor c=Ci

	R4 ( n3 out ) resistor r=Rs
	C5 ( out 0 ) capacitor c=Ce

}

if (N==5) {

	parameters Rs=Rtot/5
	parameters Ce=Ctot/10
	parameters Ci=Ctot/5

	R1 ( in n1 ) resistor r=Rs
	C1 ( in 0 ) capacitor c=Ce
	C2 ( n1 0 ) capacitor c=Ci

	R2 ( n1 n2 ) resistor r=Rs
	C3 ( n2 0 ) capacitor c=Ci

	R3 ( n2 n3 ) resistor r=Rs
	C4 ( n3 0 ) capacitor c=Ci

	R4 ( n3 n4 ) resistor r=Rs
	C5 ( n4 0 ) capacitor c=Ci

	R5 ( n4 out ) resistor r=Rs
	C6 ( out 0 ) capacitor c=Ce

}

if (N==6) {

	parameters Rs=Rtot/6
	parameters Ce=Ctot/12
	parameters Ci=Ctot/6

	R1 ( in n1 ) resistor r=Rs
	C1 ( in 0 ) capacitor c=Ce
	C2 ( n1 0 ) capacitor c=Ci

	R2 ( n1 n2 ) resistor r=Rs
	C3 ( n2 0 ) capacitor c=Ci

	R3 ( n2 n3 ) resistor r=Rs
	C4 ( n3 0 ) capacitor c=Ci

	R4 ( n3 n4 ) resistor r=Rs
	C5 ( n4 0 ) capacitor c=Ci

	R5 ( n4 n5 ) resistor r=Rs
	C6 ( n5 0 ) capacitor c=Ci

	R6 ( n5 out ) resistor r=Rs
	C7 ( out 0 ) capacitor c=Ce

}

if (N == 7) {

	parameters Rs=Rtot/7
	parameters Ce=Ctot/14
	parameters Ci=Ctot/7

	R1 (in n1) resistor r=Rs
	C1 (in 0) capacitor c=Ce
	C2 (n1 0) capacitor c=Ci

	R2 (n1 n2) resistor r=Rs
	C3 (n2 0) capacitor c=Ci

	R3 (n2 n3) resistor r=Rs
	C4 (n3 0) capacitor c=Ci

	R4 (n3 n4) resistor r=Rs
	C5 (n4 0) capacitor c=Ci

	R5 (n4 n5) resistor r=Rs
	C6 (n5 0) capacitor c=Ci

	R6 (n5 n6) resistor r=Rs
	C7 (n6 0) capacitor c=Ci

	R7 (n6 out) resistor r=Rs
	C8 (out 0) capacitor c=Ce

}

if (N ==8 ) {

	parameters Rs=Rtot/8
	parameters Ce=Ctot/16
	parameters Ci=Ctot/8

	R1 (in n1) resistor r=Rs
	C1 (in 0) capacitor c=Ce
	C2 (n1 0) capacitor c=Ci

	R2 (n1 n2) resistor r=Rs
	C3 (n2 0) capacitor c=Ci

	R3 (n2 n3) resistor r=Rs
	C4 (n3 0) capacitor c=Ci

	R4 (n3 n4) resistor r=Rs
	C5 (n4 0) capacitor c=Ci

	R5 (n4 n5) resistor r=Rs
	C6 (n5 0) capacitor c=Ci

	R6 (n5 n6) resistor r=Rs
	C7 (n6 0) capacitor c=Ci

	R7 (n6 n7) resistor r=Rs
	C8 (n7 0) capacitor c=Ci

	R8 (n7 out) resistor r=Rs
	C9 (out 0) capacitor c=Ce

}

if (N == 9) {

	parameters Rs=Rtot/9
	parameters Ce=Ctot/18
	parameters Ci=Ctot/9

	R1 (in n1) resistor r=Rs
	C1 (in 0) capacitor c=Ce
	C2 (n1 0) capacitor c=Ci

	R2 (n1 n2) resistor r=Rs
	C3 (n2 0) capacitor c=Ci

	R3 (n2 n3) resistor r=Rs
	C4 (n3 0) capacitor c=Ci

	R4 (n3 n4) resistor r=Rs
	C5 (n4 0) capacitor c=Ci

	R5 (n4 n5) resistor r=Rs
	C6 (n5 0) capacitor c=Ci

	R6 (n5 n6) resistor r=Rs
	C7 (n6 0) capacitor c=Ci

	R7 (n6 n7) resistor r=Rs
	C8 (n7 0) capacitor c=Ci

	R8 (n7 n8) resistor r=Rs
	C9 (n8 0) capacitor c=Ci

	R9 (n8 out) resistor r=Rs
	C10 (out 0) capacitor c=Ce

}

if (N == 10) {

	parameters Rs=Rtot/10
        parameters Ce=Ctot/20
        parameters Ci=Ctot/10

        R1 (in n1) resistor r=Rs
        C1 (in 0) capacitor c=Ce
        C2 (n1 0) capacitor c=Ci

        R2 (n1 n2) resistor r=Rs
        C3 (n2 0) capacitor c=Ci

        R3 (n2 n3) resistor r=Rs
        C4 (n3 0) capacitor c=Ci

        R4 (n3 n4) resistor r=Rs
        C5 (n4 0) capacitor c=Ci

        R5 (n4 n5) resistor r=Rs
        C6 (n5 0) capacitor c=Ci

        R6 (n5 n6) resistor r=Rs
        C7 (n6 0) capacitor c=Ci

        R7 (n6 n7) resistor r=Rs
        C8 (n7 0) capacitor c=Ci

        R8 (n7 n8) resistor r=Rs
        C9 (n8 0) capacitor c=Ci

        R9 (n8 n9) resistor r=Rs
        C10 (n9 0) capacitor c=Ci

	R10 (n9 out) resistor r=Rs
	C11 (out 0) capacitor c=Ce

}

// Transient simulation

tran1 tran stop=1n maxstep=0.1p

save in out

simulator lang=spice

.MEASURE TRAN tpd

+ TRIG V(in) VAL=VTH RISE=1
+ TARG V(out) VAL=VTH RISE=1
