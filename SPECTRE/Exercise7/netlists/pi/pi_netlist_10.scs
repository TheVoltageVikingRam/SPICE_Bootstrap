simulator lang=spectre

global 0
parameters TRP=0.632
parameters VDD=0.8
parameters Rtot=100
parameters Ctot=1p

Vin ( in 0 ) vsource type=pulse val0=0 va11=VDD delay=0 rise=5.65p fall=5.65p width=500p period=1.1n

R1 ( in n1 ) resistor r=10
C1 ( in 0 ) capacitor c=50f
C2 ( n1 0 ) capacitor c=100f

R2 ( n1 n2 ) resistor r=10
C3 ( n2 0 ) capacitor c=100f

R3 ( n2 n3 ) resistor r=10
C4 ( n3 0 ) capacitor c=100f

R4 ( n3 n4 ) resistor r=10
C5 ( n4 0 ) capacitor c=100f

R5 ( n4 n5 ) resistor r=10
C6 ( n5 0 ) capacitor c=100f

R6 ( n5 n6 ) resistor r=10
C7 ( n6 0 ) capacitor c=100f

R7 ( n6 n7 ) resistor r=10
C8 ( n7 0 ) capacitor c=100f

R8 ( n7 n8 ) resistor r=10
C9 ( n8 0 ) capacitor c=100f

R9 ( n8 n9 ) resistor r=10
C10 ( n9 0 ) capacitor c=100f

R10 ( n9 out ) resistor r=10
C11 ( out 0 ) capacitor c=50f

tran10 tran stop=1n maxstep=0.1p

save in out n1 n2 n3 n4 n5 n6 n7 n8 n9

simulator lang=spice

.MEASURE TRAN tpd

+ TRIG V(in) VAL=TRP*VDD RISE=1
+ TARG V(out) VAL=TRP*VDD RISE=1
