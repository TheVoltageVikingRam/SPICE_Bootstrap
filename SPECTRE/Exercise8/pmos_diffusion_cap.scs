simulator lang=spectre

global 0 vdd vss

include "22nm_HP.pm"

parameters VD_VAL=0

parameters Wn=44n
parameters Ln=22n

parameters k=1.3
parameters Wp=k*Wn
parameters Lp=Ln

parameters as_n = Wn*Ln*1.5
parameters ad_n = Wn*Ln*1.5
parameters ps_n = 2*Wn+3*Ln
parameters pd_n = 2*Wn+3*Ln

parameters as_p = Wp*Lp*1.5
parameters ad_p = Wp*Lp*1.5
parameters ps_p = 2* Wp+3*Lp
parameters pd_p = 2*Wp+3*Lp

vdd_I1 ( vdd 0 ) vsource dc=0.8
vss_I1 ( vss 0 ) vsource dc=0

M1 ( net1 vdd vdd vdd ) pmos w=Wp l=Lp ad=ad_p as=as_p pd=pd_p ps=ps_p
PORT0 ( net1 0 ) vsource dc=VD_VAL type=sine ampl=1m mag=1m phase=0

sweepVD sweep param=VD_VAL values=[0 0.2 0.4 0.6 0.8] {

ac1 ac start=100 stop=10M step=1000 annotate=status

}

save PORT0:p
saveOptions options save=allpub
