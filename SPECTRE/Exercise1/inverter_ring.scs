// INVERTER CHAIN

simulator lang=spectre
global 0 vdd vss
include "./22nm_HP.pm"

vdd_I1 ( vdd 0 ) vsource dc=0.8
vss_I1 ( vss 0 ) vsource dc=0

*********INVERTER***************
parameters L=22n Ln=L Wn=2*Ln k=2
subckt inv (out in)
m1 ( out in vdd vdd ) pmos l=L w=k*Wn
m2 ( out in vss vss ) nmos l=Ln w=Wn

//Interconnect caps

// c0 ( in vdd ) capacitor c=1.0824323e-16
// c1 ( in out ) capacitor c=3.0044e-16
// c2 ( out vss ) capacitor c=5.00186e-16
// c3 ( out vdd ) capacitor c=6.913993e-16
// c4 ( in vss ) capacitor c=8.5372566e-16
ends inv

***************TOP LEVEL CIRCUIT - NON RING INVERTERS CHAINS **********

xinv1 ( 1 in1 ) inv
xinv2 ( 2 1 ) inv
xinv3 ( 3 2 ) inv
xinv4 ( 4 3 ) inv
xinv5 ( 5 4 ) inv
xinv6 ( 6 5 ) inv
xinv7 ( out1 6 ) inv

//Instantiation of piece wise linear model

parameters VDD=0.8 X=10p

V1 (in1 0) vsource type=pwl wave=[ 0 VDD X 0 40n 0 (40n+X) VDD (80n+X) VDD ]

// Transient Analysis run

//tran_run tran stop=85n step=1p

//Saving the outputs to view in waveform viewer

ksweep sweep param=k start=1 stop=2 step=0.1 {
tran_run2 tran stop=85n step=1p
}

//save in1 3 4 out1

simulator lang=spice

.MEASURE TRAN tphl TRIG V(3) VAL='VDD/2' RISE=1
+ TARG V(4) VAL='VDD/2' FALL=1

.MEASURE TRAN tplh TRIG V(3) VAL='VDD/2' FALL=1
+ TARG V(4) VAL='VDD/2' RISE=1

simulator lang=spectre

print tphl
print tplh

compare(getData("tphl" ?result "transient1_meas-meas_foreach" ?resultsDir "./results.dir") getData("tplh" ?result "transient1_meas-meas_foreach" ?resultsDir "./results.dir") 0.0 0.0 )
