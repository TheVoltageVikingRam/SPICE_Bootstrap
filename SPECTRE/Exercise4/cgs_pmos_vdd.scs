// Gate capacitance of nmos transistoir with drain and source connected to vdd

simulator lang=spectre

global 0 vdd vss

parameters VG_VAL=0.8

include "22nm_HP.pm"
parameters k=1.3
parameters Wn=44n
parameters Ln=22n
parameters Lp=Ln
parameters Wp=k*Wn

vdd_I1 ( vdd 0 ) vsource dc=0.8
vss_I1 ( vss 0 ) vsource dc=0

// Transistor Instantiation

M2 ( vdd net2 vdd vdd ) pmos w=Wp l=Lp

PORT2 (net2 0) vsource dc=VG_VAL type=sine ampl=1m mag=1m phase=0

sweepVG sweep param=VG_VAL values=[0.2 0.4 0.6 0.8] {

ac1 ac start=100 stop=10M step=1000 annotate=status

}

save PORT0:p

saveOptions options save=allpub
