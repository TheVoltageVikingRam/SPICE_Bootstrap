* capdelay.hsp
* Extract effective gate capacitance for delay estimation
*-----------------------------------------------------------
* Parameters and models
*-----------------------------------------------------------

.option scale=25n
.param SUP=1.0   * Must set before calling .lib
.lib '../models/ibm065/opconditions.lib' TT
.option post

*-------------------------------------------------------------
* Subcircuits
*-------------------------------------------------------------

.global vdd gnd
.subckt inv a y
M1 y a gnd gnd NMOS W=16 L=2 AD=0 AS=0 PD=0 PS=0
M2 y a vdd vdd PMOS W=32 L=2 AD=0 AS=0 PD=0 PS=0
.ends

*-------------------------------------------------------------
* Simulation netlist
*-------------------------------------------------------------

Vdd vdd gnd 'SUPPLY'        * SUPPLY is set by .lib call
Vin a   gnd  pulse 0 'SUPPLY' 0ps 20ps 20ps 120ps 280ps
X1  a    b    inv             * Set appropriate slope
X2  b    c    inv  M=4        * Set appropriate slope
X3  c    d    inv  M=8        * drive real load
X4  d    e    inv  M=32       * real load
X5  e    f    inv  M=64       * load on load (important)
X6  c    g    inv  M=8        *drive linear capacitor
cdelay g gnd 'CperMicron*32*(16+32)*25n/1u'      * linear capacitor

*-----------------------------------------------------------
* Optimization Setup
*-----------------------------------------------------------

.measure errorR param='invR-capR' goal=0
.measure errorF param='invF-capF' goal=0
.param CperMicron=optrange(2f, 0.2f, 3.0f)
.model optmod opt itropt=30
.measure CperMic param='CperMicron'

*-----------------------------------------------------------
* Stimulus
*-----------------------------------------------------------

.tran 1ps 280ns SWEEP OPTIMIZE = optrange RESULTS=errorR, errorF, MODEL=optmod

.measure invR
+  TRIG v(c) VAL='SUPPLY/2' FALL=1
+  TARG v(d) VAL='SUPPLY/2' RISE=1

.measure capR
+  TRIG  v(c) VAL='SUPPLY/2' FALL=1
+  TARG  v(d) VAL='SUPPLY/2' RISE=1

.measure invF
+  TRIG v(c) VAL='SUPPLY/2' RISE=1
+  TARG v(d) VAL='SUPPLY/2' FALL=1

.measure capF
+  TRIG v(c) VAL='SUPPLY/2' RISE=1
+  TARG v(d) VAL='SUPPLY/2' FALL=1

.end
